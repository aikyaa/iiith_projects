2023102062_Aikya
.include TSMC_180nm.txt
.param SUPPLY=1.8
.param LAMBDA=0.09u
.global gnd vdd
.param width_P={12*LAMBDA}
.param width_N={6*LAMBDA}
Vdd	vdd	gnd	'SUPPLY'

v1 A gnd pulse(0 1.8 0ns 0ns 0ns 30ns 60ns)
v2 B gnd pulse(0 1.8 0ns 0ns 0ns 20ns 40ns)

.subckt inv A Anot
M1 Anot A vdd vdd CMOSP l={2*LAMBDA} w={2*width_n}
+ad={5*2*width_n *LAMBDA} as={5*2*width_n *LAMBDA} pd={10*LAMBDA+2*2*width_n} ps={10*LAMBDA+2*2*width_n}
M2 Anot A gnd gnd CMOSN l={2*LAMBDA} w={width_n}
+ad={5*width_n *LAMBDA} as={5*width_n *LAMBDA} pd={10*LAMBDA+2*width_n} ps={10*LAMBDA+2*width_n}
.ends inv

.subckt nor A B AnorB
M4 vdd B jn vdd CMOSP l={2*LAMBDA} w={4*width_n}
+ad={5*4*width_n *LAMBDA} as={5*4*width_n *LAMBDA} pd={10*LAMBDA+2*4*width_n} ps={10*LAMBDA+2*4*width_n}
M1 jn A AnorB vdd CMOSP l={2*LAMBDA} w={4*width_n}
+ad={5*4*width_n *LAMBDA} as={5*4*width_n *LAMBDA} pd={10*LAMBDA+2*4*width_n} ps={10*LAMBDA+2*4*width_n}
M2 AnorB A gnd gnd CMOSN l={2*LAMBDA} w={width_n}
+ad={5*width_n *LAMBDA} as={5*width_n *LAMBDA} pd={10*LAMBDA+2*width_n} ps={10*LAMBDA+2*width_n}
M3 AnorB B gnd gnd CMOSN l={2*LAMBDA} w={width_n}
+ad={5*width_n *LAMBDA} as={5*width_n *LAMBDA} pd={10*LAMBDA+2*width_n} ps={10*LAMBDA+2*width_n}
.ends nor

.subckt or A B AorB
x2 A B AorBnot nor
x1 AorBnot AorB inv
.ends or

x1 A B out or

.tran 0.01n 250n

.control
set color0 = white
run
plot v(out) 4+v(A) 2+v(B)
.endc
