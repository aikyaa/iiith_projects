2023102062_Aikya
.include TSMC_180nm.txt
.param SUPPLY=1.8
.param LAMBDA=0.09u
.global gnd vdd
.param width_P={12*LAMBDA}
.param width_N={6*LAMBDA}
Vdd	vdd	gnd	'SUPPLY'

v1 A gnd pulse(0 1.8 0ns 0ns 0ns 30ns 60ns)

.subckt inv A Anot
M1 Anot A vdd vdd CMOSP l={2*LAMBDA} w={2*width_n}
+ad={5*2*width_n *LAMBDA} as={5*2*width_n *LAMBDA} pd={10*LAMBDA+2*2*width_n} ps={10*LAMBDA+2*2*width_n}
M2 Anot A gnd gnd CMOSN l={2*LAMBDA} w={width_n}
+ad={5*width_n *LAMBDA} as={5*width_n *LAMBDA} pd={10*LAMBDA+2*width_n} ps={10*LAMBDA+2*width_n}
.ends inv

x1 A Ac inv

.tran 0.01n 250n

.control
set color0 = white
run
plot v(A)+2 v(Ac)
.endc
