2023102062_Aikya
.include TSMC_180nm.txt
.param SUPPLY=1.8
.param LAMBDA=0.09u
.global gnd vdd
.param width_P={12*LAMBDA}
.param width_N={6*LAMBDA}
Vdd	vdd	gnd	'SUPPLY'

vdata A gnd pulse(0 1.8 0ns 0ns 0ns 30ns 60ns)
vclk B gnd pulse(0 1.8 0ns 0ns 0ns 20ns 40ns)

* SPICE3 file created from pgAxB.ext - technology: scmos

.option scale=0.09u

M1000 nor_0/a_13_6# A vdd vdd CMOSP w=24 l=2
+  ad=192 pd=64 as=240 ps=126
M1001 gnd B P Gnd CMOSN w=6 l=2
+  ad=120 pd=78 as=48 ps=28
M1002 P B nor_0/a_13_6# vdd CMOSP w=24 l=2
+  ad=120 pd=58 as=0 ps=0
M1003 P A gnd Gnd CMOSN w=6 l=2
+  ad=0 pd=0 as=0 ps=0
M1004 nand_0/a_13_n26# A gnd Gnd CMOSN w=12 l=2
+  ad=96 pd=40 as=0 ps=0
M1005 G A vdd vdd CMOSP w=12 l=2
+  ad=96 pd=40 as=0 ps=0
M1006 vdd B G vdd CMOSP w=12 l=2
+  ad=0 pd=0 as=0 ps=0
M1007 G B nand_0/a_13_n26# Gnd CMOSN w=12 l=2
+  ad=60 pd=34 as=0 ps=0
M1008 AxB B Ac Gnd CMOSN w=6 l=2
+  ad=30 pd=22 as=60 ps=44
M1009 AxB B A vdd CMOSP w=12 l=2
+  ad=60 pd=34 as=1 ps=1
M1010 Ac A vdd vdd CMOSP w=12 l=2
+  ad=60 pd=34 as=60 ps=34
M1011 Ac A gnd Gnd CMOSN w=6 l=2
+  ad=0 pd=0 as=30 ps=22
C0 B Ac 0.20fF
C1 AxB vdd 0.03fF
C2 vdd B 0.06fF
C3 A vdd 0.06fF
C4 B vdd 0.06fF
C5 AxB A 0.15fF
C6 A gnd 0.05fF
C7 vdd P 0.03fF
C8 gnd Ac 0.10fF
C9 A vdd 0.02fF
C10 vdd Ac 0.03fF
C11 vdd G 0.28fF
C12 vdd P 0.05fF
C13 B P 0.16fF
C14 G vdd 0.04fF
C15 B G 0.13fF
C16 AxB Ac 0.06fF
C17 B vdd 0.06fF
C18 vdd A 0.02fF
C19 Ac vdd 0.15fF
C20 A Ac 0.04fF
C21 AxB B 0.04fF
C22 vdd A 0.06fF
C23 B gnd 0.05fF
C24 B vdd 0.04fF
C25 A vdd 0.06fF
C26 A B 1.44fF
C27 P gnd 0.18fF
C28 gnd A 0.05fF
C29 vdd vdd 0.08fF
C30 vdd vdd 0.06fF
C31 A P 0.02fF
C32 vdd A 0.06fF
C33 G gnd 0.03fF
C34 vdd vdd 0.10fF
C35 gnd Gnd 0.10fF
C36 AxB Gnd 0.06fF
C37 Ac Gnd 0.12fF
C38 vdd Gnd 0.05fF
C39 vdd Gnd 0.58fF
C40 vdd Gnd 0.58fF
C41 G Gnd 0.08fF
C42 vdd Gnd 0.82fF
C43 gnd Gnd 0.26fF
C44 P Gnd 0.09fF
C45 vdd Gnd 0.11fF
C46 B Gnd 0.63fF
C47 A Gnd 0.50fF
C48 vdd Gnd 1.23fF

.tran 0.01n 250n
.control
set color0 = white
run
plot v(G) 2+(P) 6+v(A) 4+v(B)
.endc
* drain gate source body
