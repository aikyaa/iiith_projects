2023102062_Aikya
.include TSMC_180nm.txt
.param SUPPLY=1.8
.param LAMBDA=0.09u
.global gnd vdd
.param width_P={12*LAMBDA}
.param width_N={6*LAMBDA}
Vdd	vdd	gnd	'SUPPLY'

vdata D gnd pulse(0 1.8 0ns 0ns 0ns 30ns 60ns)
vclk clk gnd pulse(0 1.8 0ns 0ns 0ns 20ns 40ns)

.option scale=0.09u

M1000 out jn3 inv_0/vdd vdd CMOSP w=12 l=2
+  ad=60 pd=34 as=60 ps=34
M1001 out jn3 inv_0/gnd Gnd CMOSN w=6 l=2
+  ad=30 pd=22 as=30 ps=22
M1002 jn3 jn2 vdd vdd CMOSP w=12 l=2
+  ad=60 pd=34 as=240 ps=126
M1003 a_17_4# jn2 gnd Gnd CMOSN w=6 l=2
+  ad=60 pd=44 as=90 ps=66
M1004 jn2 jn1 vdd vdd CMOSP w=12 l=2
+  ad=60 pd=34 as=0 ps=0
M1005 jn3 jn1 a_17_4# Gnd CMOSN w=6 l=2
+  ad=30 pd=22 as=0 ps=0
M1006 jn2 jn1 a_n27_5# Gnd CMOSN w=6 l=2
+  ad=30 pd=22 as=60 ps=44
M1007 a_n60_n13# jn1 a_n67_n13# vdd CMOSP w=24 l=2
+  ad=240 pd=116 as=120 ps=58
M1008 a_n60_n13# D vdd vdd CMOSP w=24 l=2
+  ad=0 pd=0 as=0 ps=0
M1009 a_n27_5# jn1 gnd Gnd CMOSN w=6 l=2
+  ad=0 pd=0 as=0 ps=0
M1010 jn1 D gnd Gnd CMOSN w=6 l=2
+  ad=30 pd=22 as=0 ps=0
C0 vdd jn1 0.09fF
C1 jn1 jn3 0.04fF
C2 vdd a_n60_n13# 0.05fF
C3 inv_0/vdd jn3 0.02fF
C4 vdd D 0.08fF
C5 inv_0/gnd jn3 0.05fF
C6 a_n27_5# gnd 0.10fF
C7 out inv_0/vdd 0.15fF
C8 D vdd 0.03fF
C9 out inv_0/gnd 0.10fF
C10 a_17_4# jn2 0.08fF
C11 vdd jn3 0.15fF
C12 vdd a_n60_n13# 0.05fF
C13 jn1 vdd 0.10fF
C14 vdd vdd 0.06fF
C15 gnd jn2 0.05fF
C16 vdd jn3 0.06fF
C17 a_n27_5# jn1 0.18fF
C18 a_17_4# gnd 0.10fF
C19 jn1 vdd 0.05fF
C20 a_n60_n13# vdd 0.27fF
C21 jn2 jn3 0.04fF
C22 out vdd 0.03fF
C23 vdd vdd 0.07fF
C24 vdd vdd 0.06fF
C25 vdd jn2 0.10fF
C26 a_17_4# jn3 0.06fF
C27 inv_0/vdd vdd 0.06fF
C28 gnd D 0.05fF
C29 vdd a_n67_n13# 0.03fF
C30 jn1 jn2 0.21fF
C31 a_17_4# jn1 0.03fF
C32 jn2 vdd 0.03fF
C33 jn1 a_n67_n13# 0.04fF
C34 a_n60_n13# a_n67_n13# 0.25fF
C35 a_n27_5# jn2 0.09fF
C36 gnd jn1 0.16fF
C37 vdd jn3 0.03fF
C38 vdd jn2 0.20fF
C39 jn1 D 0.22fF
C40 D a_n60_n13# 0.04fF
C41 out jn3 0.04fF
C42 gnd Gnd 0.20fF
C43 jn1 Gnd 0.62fF
C44 a_17_4# Gnd 0.02fF
C45 a_n27_5# Gnd 0.11fF
C46 vdd Gnd 0.01fF
C47 jn2 Gnd 0.21fF
C48 a_n60_n13# Gnd 0.03fF
C49 D Gnd 0.45fF
C50 vdd Gnd 0.87fF
C51 vdd Gnd 0.58fF
C52 vdd Gnd 0.53fF
C53 inv_0/gnd Gnd 0.10fF
C54 out Gnd 0.05fF
C55 inv_0/vdd Gnd 0.05fF
C56 jn3 Gnd 0.12fF
C57 vdd Gnd 0.58fF
.measure tran delay
+ TRIG v(clk) VAL='0.5*SUPPLY' RISE=1
+ TARG v(out) VAL='0.5*SUPPLY' RISE=1

.tran 0.01n 500n
.control
set color0 = white
run
plot v(out) 4+v(D) 2+v(clk)
.endc
* drain gate source body
